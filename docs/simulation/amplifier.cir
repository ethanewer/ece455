* Generated by `python3 -m util.simulate` from ltspice/AmplificationSim.asc.
* tol = 0; V1 carries AC 1 for gain and noise analyses.
* AmplificationSim, tol = 0
.param Cnom=180n
.param tol=0
C1 c1_1 0 {Cnom*(1+tol)}
C2 AIN1 VopAmpOut2 1uF
C3 AIN1 0 20p
C4 c4_1 c1_1 1uF
C5 c5_1 VopAmpOut1 4.6nF
C6 VopAmpOut2 c6_2 18nF
C7 n25P 0 20p
C8 c8_1 c4_1 2p
C9 c9_1 c5_1 2p
L1 c1_1 L1_rser 28.11m
RL1_rser L1_rser l1_2 1m
R1 AIN1 0 10Meg
R10 c9_1 c6_2 50k
R11 n25P c9_1 1K
R12 VopAmpOut2 0 33k
R13 n25P 0 10Meg
R14 c8_1 c4_1 1T
R15 c9_1 c5_1 1T
R2 n25P AIN1 10k
R3 c8_1 VopAmpOut1 50k
R4 n25P c8_1 1K
R5 l1_2 r5_2 39
R8 c4_1 n25P 1Meg
R9 c5_1 r9_2 33k
XU1 c4_1 c8_1 n5P 0 VopAmpOut1 universalopamp2 avol=316k gbw=3Meg slew=2.4Meg ilimit=7m rail=0.1 vos=0.5m en=2.7n enk=240 in=0.6f ink=0 rin=1e15
XU2 c5_1 c9_1 n5P 0 c6_2 universalopamp2 avol=316k gbw=3Meg slew=2.4Meg ilimit=7m rail=0.1 vos=0.5m en=2.7n enk=240 in=0.6f ink=0 rin=1e15
V1 r5_2 0 DC 0 SIN(0 10uV 2268 0 1.0526 0) AC 1
V5 r9_2 0 DC 2.5
* V6 (SINE(0 100u 60)) is not connected in the schematic.
V8 n5P 0 DC 5V
V9 n25P 0 DC 2.5V
* ngspice equivalent of LTspice's UniversalOpAmp2 (SpiceModel level2): a
* transconductance stage into one internal node with Rout and Cout, the
* slew-rate limit as a limit on that stage's output current, and an output
* that stays Rail volts inside each supply. Ilimit is accepted but the
* output current limit is not modeled. En and In are white noise densities;
* Enk and Ink are their 1/f corner frequencies. Controlled sources are
* noiseless; each noise resistor drives only a controlling input.
.subckt universalopamp2 inp inn vp vn out params: avol=1Meg gbw=10Meg slew=10Meg
+ ilimit=25m rail=0 vos=0 en=0 enk=0 in=0 ink=0 rin=500Meg
.param rout=100Meg
.param cout={avol/gbw/(2*3.141592653589793)/rout}
.param gm={avol/rout}
.param imax={slew*cout}
.param fourkt={4*1.380649e-23*300.15}
.param rv={max(en*en/fourkt, 1e-6)}
.param gi={in/sqrt(fourkt*1k)}
* Input resistance Rin from each input to mid-supply.
Grin1 vp inp vp inp {0.5/rin}
Grin2 inp vn inp vn {0.5/rin}
Grin3 vp inn vp inn {0.5/rin}
Grin4 inn vn inn vn {0.5/rin}
* Input voltage noise: thermal noise of rv, plus 1/f noise from 1 mA in it.
Iv 0 nv DC 1m
Rv nv 0 rflickv r={rv}
.model rflickv R(kf={en*en*enk/(rv*rv*1e-6)} af=2)
* Input current noise on each input from 1 kohm noise resistors.
Ii1 0 ni1 DC 1m
Ri1 ni1 0 rflicki r=1k
Ii2 0 ni2 DC 1m
Ri2 ni2 0 rflicki r=1k
.model rflicki R(kf={in*in*ink/max(gi*gi, 1e-60)} af=2)
Bi1 inp 0 I={gi}*(V(ni1)-1)
Bi2 inn 0 I={gi}*(V(ni2)-1)
* Transconductance stage with the slew-rate current limit.
Bgm 0 x I=min(max({gm}*(V(inp)-V(inn)+V(nv)-{rv*1m}+{vos}), -{imax}), {imax})
Grout1 vp x vp x {0.5/rout}
Grout2 x vn x vn {0.5/rout}
Cx x 0 {cout}
Bclamp1 x 0 I=V(x) > V(vp) ? pwr({2*slew*cout}*(V(x)-V(vp)), 2) : 0
Bclamp2 0 x I=V(x) < V(vn) ? pwr({2*slew*cout}*(V(vn)-V(x)), 2) : 0
* Output follows x through 10 ohms, Rail volts inside each supply.
Bout o 0 V=min(max(V(x), V(vn)+{rail}), V(vp)-{rail})
Gout o out o out 0.1
.ends universalopamp2
.end
