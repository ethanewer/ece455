* Lab-parts receiver input for the purchased HiLetgo ADS1256 module.
* Coil, tuning capacitor, and damping resistor are external to J1.
* The ADS1256's own input buffer and PGA are the first active stage.
.param fL=1765
.param V0=10u
.param T2s=0.95
.param PGA=64

* External source fixture, not fitted receiver components. The 30 kohm
* Thevenin impedance is provisional until the tuned sensor is measured.
Vfid source 0 DC 0 AC 1 SINE(0 {V0} {fL} 0 {1/T2s})
Rsource source receiver_in 30k

* Kit-only analog path. C5 isolates the sensor's DC level. R1 limits
* current into the kit 1N4148 clamps. R2+R3 return AIN0 to the bias.
* C9 is small enough to preserve high input impedance at FID frequencies.
* High-pass and narrow-band processing must be performed digitally.
C5 receiver_in coupled 22n
R1 coupled ads_ain0 10k
R2 ads_ain0 bias_mid 1Meg
R3 bias_mid vref 1Meg
C9 ads_ain0 vref 100p
D1 vref ads_ain0 KIT4148
D2 ads_ain0 vref KIT4148

* Low-impedance 1.60 V common-mode bias from USB 5 V. The 47 uF kit
* electrolytic and 100 nF ceramic suppress supply noise and clamp pulses.
Vusb vbus5 0 5
R4 vbus5 vref 1k
R5 vref 0 470
C6 vref 0 47u
C7 vref 0 100n
C14 vbus5 0 1u

* At 30 kSPS with BUFEN=1, TI lists 10 Megohm effective differential
* input impedance. A noiseless conductance models loading without
* pretending that a switched input has resistor thermal noise.
Gads ads_ain0 vref ads_ain0 vref 100n
Cads ads_ain0 vref 5p

* The ADS1256 internal PGA is represented for transfer plots only.
* The specified 1.742 uV rms converter noise at PGA=64 and 30 kSPS,
* digital filtering, and recovery after SYNC are not in this SPICE deck.
Epga pga_out 0 ads_ain0 vref {PGA}
Rload pga_out 0 1Meg

* Purchased XIAO RP2350: D8/GPIO2 SCLK, D10/GPIO3 MOSI,
* D9/GPIO4 MISO, D3/GPIO5 CS, D2/GPIO28 DRDY, D4/GPIO6 PDWN.
* Ignore ADC samples during the 200 ms acquisition blank. Then give
* SYNC/PDWN a short pulse (under 20 DRDY periods) and wait for DRDY.
* Holding it low for the whole interval would power down the oscillator.
* No analog blanking switch is fitted.

.model KIT4148 D(Is=4n Rs=0.6 Cjo=4p Bv=75 Ibv=5u)
.options plotwinsize=0
.ac dec 1000 100 100k
.noise V(pga_out) Vfid dec 200 100 6106
.save all
.end
