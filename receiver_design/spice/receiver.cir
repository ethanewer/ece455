* Minimal discrete low-noise bandpass receiver for the HiLetgo ADS1256.
* Requirements (receiver_design/requirements.py, enforced by make verify):
* gain >= 2000 V/V from J1 to AIN0-AIN1 across 1.6-2.2 kHz, |Zin| >= 1
* Megohm across 1.5-2.5 kHz, and input noise <= 5 nV/rtHz with the coil.
* Every fitted part except the ADC module and XIAO RP2350 is a Thomson kit
* part listed in new_allowed_components.json. No op-amp is used.
* The coil, tuning capacitor, and damping resistor are external to J1.
.param fL=1765
.param V0=10u
.param T2s=0.95
.param PGA=1

* External source fixture, not fitted receiver components. The 30 kohm
* Thevenin impedance represents the externally tuned sensor and is
* provisional until the tuned sensor is measured.
Vfid source 0 DC 0 AC 1 SINE(0 {V0} {fL} 0 {1/T2s})
Rsource source receiver_in 30k

* Input clamps: diode-connected 2N3904s (collector tied to base). Their
* femtoamp saturation current keeps clamp leakage from loading the
* megohm input, unlike 1N4148s. They hold J1 within about +/-0.65 V.
Q5 receiver_in receiver_in 0 Q2N3904
Q6 0 0 receiver_in Q2N3904

* Stage 1, AC gain 1+R7/R8 = 35. Q1 (about 32 uA, set by Q2's VBE across
* R4) is the only noise-critical device. Q2 is a second gain stage and Q3
* a follower that drives the feedback network. Stage-1 loop gain is about
* 30, which raises Q1's base impedance to megohms. C4 sets unity DC gain
* and a 480 Hz high-pass corner.
C1 receiver_in q1_base 100n
Q1 q1_col q1_base q1_emit Q2N3904
R4 va q1_col 20k
Q2 q2_col q1_col va Q2N3906
R5 q2_col 0 20k
Q3 va q2_col stage1_out Q2N3904
R6 stage1_out 0 4.7k
R7 stage1_out q1_emit 5.1k
R8 q1_emit stage1_ac 150
C4 stage1_ac 0 2.2u

* Stage 2: common emitter, gain about 95 = (VA - VOUT)/VT with R9
* bypassed by C5. C7 to ground forms the band-pass filter's 5.3 kHz
* low-pass pole with R10.
Q4 out stage1_out q4_emit Q2N3904
R9 q4_emit 0 1k
C5 q4_emit 0 2.2u
R10 va out 20k
C7 out 0 1.5n

* Bias and DC loop. R3 feeds the inverted output back to Q1's base through
* the low-pass node BIAS (C3). This sets every operating point, placing the
* output near 2.3 V and BIAS near 1.7 V. C2 bootstraps R1 from Q1's emitter,
* which follows the input, so R1 presents tens of megohms in band.
* BIAS is quiet, so it is also ADS1256 AIN1.
R1 q1_base boot 470k
C2 boot q1_emit 100n
R2 boot bias 100k
C3 bias 0 100n
R3 out bias 1Meg

* Band-pass filter high side: Sallen-Key high-pass, f0 1.1 kHz and Q 1.05,
* buffered by the Q7 follower, which drives ADS1256 AIN0. R13 references
* the section to BIAS, so AIN0 sits near 1.1 V. Q7 runs near 11 uA so its
* base current barely disturbs the DC loop through R3.
C8 out hp_a 1n
C9 hp_a hp_b 1n
R12 hp_a ain0 68k
R13 hp_b bias 300k
Q7 va hp_b ain0 Q2N3904
R14 ain0 0 100k

* Analog rail: R11/C6 filter the XIAO USB 5 V; VA is about 4.83 V at
* 0.36 mA.
Vusb vbus5 0 5
R11 vbus5 va 470
C6 va 0 470u

* ADS1256 with BUFEN=1: 10 Megohm effective differential input at 30 kSPS.
* A noiseless conductance models loading without pretending that a
* switched input has resistor thermal noise. AIN1 is BIAS.
Gads ain0 bias ain0 bias 100n
Cads ain0 bias 5p

* ADS1256 configuration: AIN0-AIN1, buffer on, PGA=1, 30 kSPS. PGA 1 gives
* +/-5 V full scale and 10.7 uV rms converter noise, about 4.5 nV rms
* referred to J1. The converter noise and digital filter are not in this deck.
Epga pga_out 0 ain0 bias {PGA}
Rload pga_out 0 1Meg

* Purchased XIAO RP2350 wired directly to the module (3.3 V SPI):
* D8/GPIO2 SCLK, D10/GPIO3 MOSI to DIN, D9/GPIO4 MISO from DOUT,
* D3/GPIO5 CS, D2/GPIO28 DRDY, D4/GPIO6 SYNC/PDWN.
* Ignore ADC samples during the acquisition blank. Then give
* SYNC/PDWN a short pulse (under 20 DRDY periods) and wait for DRDY.
* Holding it low for the whole interval would power down the oscillator.

* Vendor Gummel-Poon models (the widely distributed Fairchild/onsemi set).
* Rb=10 ohm is optimistic for 2N3904 base resistance, and KF/AF 1/f noise
* is absent. Measure the assembled noise floor.
.model Q2N3904 NPN(Is=6.734f Xti=3 Eg=1.11 Vaf=74.03 Bf=416.4 Ne=1.259
+ Ise=6.734f Ikf=66.78m Xtb=1.5 Br=.7371 Nc=2 Isc=0 Ikr=0 Rc=1 Cjc=3.638p
+ Mjc=.3085 Vjc=.75 Fc=.5 Cje=4.493p Mje=.2593 Vje=.75 Tr=239.5n
+ Tf=301.2p Itf=.4 Vtf=4 Xtf=2 Rb=10)
.model Q2N3906 PNP(Is=1.41f Xti=3 Eg=1.11 Vaf=18.7 Bf=180.7 Ne=1.5 Ise=0
+ Ikf=80m Xtb=1.5 Br=4.977 Nc=2 Isc=0 Ikr=0 Rc=2.5 Cjc=9.728p Mjc=.5776
+ Vjc=.75 Fc=.5 Cje=8.063p Mje=.3677 Vje=.75 Tr=33.42n Tf=179.3p Itf=.4
+ Vtf=4 Xtf=6 Rb=10)
.options plotwinsize=0
.ac dec 1000 100 100k
* Integrate through the ADS1256's 6.106 kHz digital-filter bandwidth.
.noise V(pga_out) Vfid dec 200 100 6106
.save all
.end
