* Complete receiver using the HiLetgo ADS1256 module and XIAO RP2350
* Default J4 shunt is the ~1.7 kHz tank. Set Vjumper=1 and fL to the
* alternate resonance to simulate the ~2.1 kHz tank. ADS1256 at 30 kSPS,
* differential, PGA=64.
.param fL=1792.019986
.param V0=3.642200856u
.param Vjumper=0
* R17 and R21 model the J4 shunt: 0.01 ohm on the selected bank and
* 1 terohm on the other. Vjumper=0 selects the 1792 Hz bank.
.param Rlo={1e12*Vjumper + 0.01*(1-Vjumper)}
.param Rhi={1e12*(1-Vjumper) + 0.01*Vjumper}
.param T2s=0.95
.param VDD=3.3
.param PGA=64

* Induced FID test source and the CoilDesign.xlsx series-aiding sensing pair.
* J4 connects exactly one capacitor bank across the 99.9358 ohm, 152.5682 mH
* pair. Vjumper=0 shorts n17 (C25+C26, 1792 Hz). Vjumper=1 shorts n21
* (C27+C28, 2099 Hz). The amplifier load stays R1+R2, 8.201 megohm.
* If measured L differs, remove the shunt and fit C = 1/(4*pi^2*f^2*L)
* from J4 pin 4 (COIL_HI) to pin 2 (GND).
Vfid source 0 DC 0 AC 1 SINE(0 {V0} {fL} 0 {1/T2s})
Rcoil source coil_l 99.9358
Lcoil coil_l coil_hi 152.5682m
R17 n17 0 {Rlo}
R21 n21 0 {Rhi}
C25 coil_hi n17 47n
C26 coil_hi n17 4.7n
C27 coil_hi n21 33n
C28 coil_hi n21 4.7n

* AC coupling, clamp-current limit, 8.2 megohm bias, and default-on blanker.
* C5 with R2 is a 5.9 Hz high-pass. At 1792 Hz its reactance is 27 kilohm,
* so the tank still sees 8.20 megohm. U1B's 1.516 kHz high-pass is the
* first gain stage and is what attenuates 50/60 Hz.
C5 coil_hi protected 3.3n
R1 protected pre_in 1k
R2 pre_in vref 8.2Meg
D1 0 pre_in BAS116
D2 pre_in avdd BAS116
Sblank pre_in vref blank 0 TMUXSW
R3 avdd blank 100k
Vblank blank 0 0

* Filtered XIAO 3V3_OUT analog rail. USB VBUS separately powers ADS1256.
V3V3 xiao_3v3 0 {VDD}
Rfb xiao_3v3 avdd_f 0.25
Lfb avdd_f avdd 0.95u
C10 avdd 0 10u
C11 avdd 0 100n
C12 avdd 0 100n
C13 avdd 0 1u
Vusb vbus5 0 5
C14 vbus5 0 10u
C15 vbus5 0 100n
C16 vbus5 0 100n
C17 vbus5 0 100n
C18 vbus5 0 100n
C19 xiao_3v3 0 100n
C20 xiao_3v3 0 100n
Rfb5 vbus5 opamp_f 0.25
Lfb5 opamp_f opamp5 0.95u
C21 opamp5 0 10u
C22 opamp5 0 100n

* 1.50 V bias buffered by U1D. On a 5 V rail the OPA4197 specifies
* 5.5 nV/sqrt(Hz) only for common-mode voltage below (V+)-3 V, which is
* 2.0 V. 5*10k/(23.2k+10k) = 1.506 V, still below that boundary if USB
* sags to 4.75 V. The ADS1256 conversion reference stays the module ADR03.
R4 opamp5 vref_raw 23.2k
R5 vref_raw 0 10k
C6 vref_raw 0 10u
XU1D vref_raw vref vref opamp5 0 OPA4197

* U1A unity-gain buffer. The tank's Q is the voltage step-up. Keeping this
* stage at unity leaves 50/60 Hz for U1B to reject before the gain of 56,
* and keeps the Curie-law FID inside the ADS1256's +/-78 mV full scale.
XU1A pre_in stage1 stage1 opamp5 0 OPA4197

* U1B high-pass stage, fc=1.516 kHz and inverting gain 56.19.
C7 stage1 hp_in 100n
R8 hp_in stage2_n 1.05k
R9 stage2 stage2_n 59k
XU1B vref stage2_n stage2 opamp5 0 OPA4197

* U1C unity-gain Sallen-Key low-pass, natural frequency 3.03 kHz.
* The second pole is what rejects energy near the 30 kHz sample rate.
R10 stage2 sk_mid 10.2k
R11 sk_mid stage3_n 10.2k
C8 sk_mid stage3 6.8n
C23 stage3_n vref 3.9n
XU1C stage3_n stage3 stage3 opamp5 0 OPA4197

* Differential ADS1256 input. AIN1 is the buffered 1.50 V bias. R12/C9 add a
* 7.23 kHz differential input pole. The module's input buffer must be enabled.
* D3's cathode is 1.80 V, so the diode is reverse biased at the 1.50 V signal
* bias. A U1C output at the 5 V rail can raise AIN0 only to that cathode
* voltage plus one diode drop. The BAS116 maximum is 0.9 V at 1 mA, and the
* fault current through 10 kohm is well below 1 mA, so AIN0 stays under the
* buffer limit AVDD-2 V = 3.0 V. The BAS116 Is=2 pA model understates that drop.
R12 stage3 ads_ain0 10k
C9 ads_ain0 vref 2.2n
R14 opamp5 clamp3 1.21k
R15 clamp3 0 681
C24 clamp3 0 100n
D3 ads_ain0 clamp3 BAS116
Rads ads_ain0 vref 1G
Cads ads_ain0 vref 5p

* ADS1256 internal PGA representation. With module VREF=2.5 V and PGA=64,
* differential input full scale is nominally +/-2*VREF/PGA = +/-78.125 mV.
* This source models the selected ADC's specified PGA, not board-level gain.
Epga pga_out 0 ads_ain0 vref {PGA}
Rload pga_out 0 1Meg

* U3 XIAO RP2350 uses SPI0 through explicit 3.3V/5V logic buffers:
* D8/GPIO2 SCLK, D10/GPIO3 MOSI, D9/GPIO4 MISO, D3/GPIO5 CS,
* D2/GPIO28 DRDY, D4/GPIO6 PDWN, and D1/GPIO27 BLANK.
* ADS1256 configuration: AIN0-AIN1 differential, input buffer on, PGA=64,
* 30 kSPS. Firmware must use DRDY and report fitted frequency/field over USB.

* Compact finite-gain OPA4197 model for cross-tool AC and noise checks.
.subckt OPA4197 inp inn out vdd vss
Rdiff inp inn 1T
Renoise en 0 1826
Bplus nplus 0 V=V(inp)+V(en)
Eol raw 0 nplus inn 100k
Rdom raw nint 1k
Cdom nint 0 1.5915u
Ebuf nbuf 0 nint 0 1
Rout nbuf out 20
Cout out 0 2p
.ends OPA4197

.model BAS116 D(Is=2p Rs=1 Cjo=2p Bv=85 Ibv=100n)
.model TMUXSW SW(Ron=1.8 Roff=1T Vt=1.0 Vh=0.1)
.options plotwinsize=0
.ac dec 1000 100 100k
* Integrate through the ADS1256's 6.106 kHz digital-filter bandwidth at
* 30 kSPS (fCLK = 7.68 MHz). Energy above that bandwidth, and the converter's
* own noise, INL, clock error, and alias response, are not in this model.
.noise V(pga_out) Vfid dec 200 100 6106
.save all
.end
