* AD8421 module receiver for the HiLetgo ADS1256.
* Requirements (receiver_design/requirements.py, enforced by make verify):
* input noise <= 5 nV/rtHz with the coil, including ADS1256 converter
* noise; |Zin| >= 1 Megohm across 1.5-2.5 kHz; no clipping for 10 mV
* tones at 50-400 Hz or 2 mV at 8-50 kHz; and at least 90 dB alias
* rejection within 2.2 kHz of the ADS1256's 1.92 MHz modulator rate.
* The AD8421 module, SMA cable, and 9 V batteries are listed in
* amazon_purchases.json. The clamps, gain resistor, and filter are lab
* parts from new_allowed_components.json.
* The coil, tuning capacitor, and damping resistor are external to J1.
.param fL=1765
.param V0=10u
.param T2s=0.95

* External source fixture, not fitted receiver components. The 30 kohm
* Thevenin impedance represents the externally tuned sensor and is
* provisional until the tuned sensor is measured.
Vfid source 0 DC 0 AC 1 SINE(0 {V0} {fL} 0 {1/T2s})
Rsource source receiver_in 30k

* Input clamps: diode-connected 2N3904s (collector tied to base). Their
* femtoamp leakage does not load the megohm input. They hold J1 within
* about +/-0.65 V during the polarizer turnoff.
Q1 receiver_in receiver_in 0 Q2N3904
Q2 0 0 receiver_in Q2N3904

* AD8421 module (MOD2). The module's input jumper ties IN- to GND, and its
* input RFI parts are removed during assembly, so neither is modeled.
* R1 across the RG pins sets G = 1 + 9.9k/R1 = 100.
XMOD2 receiver_in 0 rg_a rg_b amp_out amp_ref vpos vneg AD8421_MODULE
R1 rg_a rg_b 100
* The module's BIAS trimmer and buffer drive REF. Trim the output to 2.5 V
* with J1 shorted.
Vbias amp_ref 0 2.5
* Two 9 V batteries (BT1, BT2) power the module; their midpoint is GND.
Vbat1 vpos 0 9
Vbat2 0 vneg 9

* SMA-to-Dupont cable (W1): about 30 cm of RG316 at roughly 100 pF/m.
Ccable amp_out 0 30p

* Two-section RC anti-aliasing filter at AIN0. The second section has
* ten times the impedance of the first, so they barely load each other.
* Both poles are near 7.2 kHz: -0.8 dB at 2.2 kHz, -14 dB at the 15 kHz
* Nyquist frequency, and about -96 dB at the 1.92 MHz modulator rate,
* where the ADS1256's digital filter gives no rejection. The 11 kohm in
* series also limits fault current into AIN0 to under 1 mA.
R2 amp_out aaf_mid 1k
C1 aaf_mid 0 22n
R3 aaf_mid ain0 10k
C2 ain0 0 2.2n

* ADS1256 (MOD1) configured for AIN0 - AIN1, buffer off, PGA 1, 30 kSPS.
* AIN1 is wired to GND, so AIN0 alone carries the signal. With the buffer
* off, AIN0 may span AGND - 0.1 V to AVDD + 0.1 V, and the converter adds
* 10.3 uV rms (TI Table 4). The effective input impedances at PGA 1
* (TI Table 10) are noiseless conductances, because the switched input has
* no resistor thermal noise: ZeffA 260 kohm from AIN0 to AVDD/2 and ZeffB
* 220 kohm from AIN0 to AIN1. The digital filter is not in this deck.
Eadcmid adc_mid 0 vbus5 0 0.5
Gadca ain0 adc_mid ain0 adc_mid {1/260k}
Gadcb ain0 0 ain0 0 {1/220k}

* USB 5 V from the XIAO VBUS is the ADS1256 module's AVDD.
Vusb vbus5 0 5

* Purchased XIAO RP2350 wired directly to the module (3.3 V SPI):
* D8/GPIO2 SCLK, D10/GPIO3 MOSI to DIN, D9/GPIO4 MISO from DOUT,
* D3/GPIO5 CS, D2/GPIO28 DRDY, D4/GPIO6 SYNC/PDWN.
* Ignore ADC samples during the acquisition blank. Then give
* SYNC/PDWN a short pulse (under 20 DRDY periods) and wait for DRDY.

* AD8421 behavioral model from the Rev. 0 datasheet: 30 Gohm || 3 pF
* differential and common-mode input impedance; e_ni 3.2 nV/rtHz
* (maximum), e_no 60 nV/rtHz and i_n 200 fA/rtHz (typical); G = 1 +
* 9.9k/RG; 2 MHz bandwidth at G = 100. Controlled sources are noiseless.
* Each noise resistor drives only controlling inputs, so its open-circuit
* thermal noise is the generator. Values give the datasheet densities at
* 27 C, and ngspice scales them with the circuit temperature. Output and
* input range limits are checked from the operating point in
* requirements.py rather than modeled here.
.subckt AD8421_MODULE inp inn rg1 rg2 out ref vp vn
Gzcp inp 0 inp 0 {1/30G}
Gzcn inn 0 inn 0 {1/30G}
Gzd inp inn inp inn {1/30G}
Czcp inp 0 3p
Czcn inn 0 3p
Czd inp inn 3p
* Input current noise: 1 kohm gives 4.0713 nV/rtHz; 200 fA/rtHz out.
Rnip nip 0 1k
Gnip inp 0 nip 0 4.9124e-5
Rnin nin 0 1k
Gnin inn 0 nin 0 4.9124e-5
* Input voltage noise in series with the differential input.
Rnvi nvi 0 617.8
Envi nvib 0 nvi 0 1
Ediff d nvib inp inn 1
* RG carries V(d)/RG; Vsense returns that current, and Hgain scales it.
Erg rg1 0 d 0 1
Vsense rg2 0 0
Eunity o1 ref d 0 1
Hgain o2 o1 Vsense 9.9k
* Output voltage noise.
Rnvo nvo 0 217.2k
Envo nvob 0 nvo 0 1
Enoise o3 o2 nvob 0 1
* 2 MHz output pole from noiseless elements.
Gbw 0 pole o3 0 1m
Gpl pole 0 pole 0 1m
Cpl pole 0 79.58p
Eout out 0 pole 0 1
.ends AD8421_MODULE

* Vendor Gummel-Poon model (the widely distributed Fairchild/onsemi set).
.model Q2N3904 NPN(Is=6.734f Xti=3 Eg=1.11 Vaf=74.03 Bf=416.4 Ne=1.259
+ Ise=6.734f Ikf=66.78m Xtb=1.5 Br=.7371 Nc=2 Isc=0 Ikr=0 Rc=1 Cjc=3.638p
+ Mjc=.3085 Vjc=.75 Fc=.5 Cje=4.493p Mje=.2593 Vje=.75 Tr=239.5n
+ Tf=301.2p Itf=.4 Vtf=4 Xtf=2 Rb=10)
.options plotwinsize=0
.ac dec 200 100 10Meg
* Integrate through the ADS1256's 6.106 kHz digital-filter bandwidth.
.noise V(ain0) Vfid dec 200 100 6106
.save all
.end
