* LTspice output demonstration for the optimized Week3 receiver
* Fixed tuning for the 50 uT receiver operating point
* Pipeline-equivalent model: ideal gain blocks plus scored noise parameters
* This is a conditional simulation, not a fabrication or hardware sign-off.
.param fL=2128.819237
.param V0=1.008442079u
.param T2s=0.95

* Synthetic 50 uT FID starts at turnoff and decays during receiver blanking.
Vfid fid 0 SINE(0 {V0} {fL} 0 {1/T2s}) AC 1
* The evaluator's 50 mV, 100 dB-PSRR stress appears as 0.5 uV at the input.
Vripple source fid SINE(0 0.5u 2k)

* Fixed Week3 sensing pair and the selected 50 uT tuning state.
Rcoil source nc 14
Lcoil nc nin 22m
Ctune nin 0 254.062174n

* 2N6550-class input-noise equivalent and x4 preamplifier.
Rnoise nin np 118.3
Rin np 0 1.657Meg
Epre stage1 0 np 0 4

* Recentered multiple-feedback bandpass.
R1 stage1 nA 1.700943k
R2 nA 0 1.130627k
C1 nA ninv 22n
C2 nA outbp 22n
R3 ninv outbp 17.009429k
Ebp outbp 0 ninv 0 -100k

* Anti-alias pole and ADC-domain gain.
Raa outbp naa 1k
Caa naa 0 22n
Eadc adc 0 naa 0 10

* Linear ring-down test used by the current evaluator.
Ipol nc nin PWL(0 1m 0.4m 1m 0.5m 0 230m 0)

.options plotwinsize=0
.ac dec 4000 100 10k
.noise V(adc) Vfid dec 4000 100 10k
.tran 2u 230m 190m
.save all
.end
